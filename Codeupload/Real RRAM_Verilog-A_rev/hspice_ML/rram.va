`include "constants.vams"
`include "disciplines.vams"

module linear(g, s);
parameter real		time_step	= 1e-9 from(1e-15: 20);

 inout         g,s;   // external nodes

 real W,Wa,Wb;

 real A;
 real A0[0:19]={-1.2620110511779785, 0.9600839018821716, 1.1085119247436523, -0.06836435198783875, -0.21731260418891907, -0.9469903707504272, 1.0066426992416382, -0.06778636574745178, 1.0396218299865723, -0.8710201978683472, -0.6348945498466492, 0.9339292645454407, 1.2252154350280762, 0.7964897751808167, -0.9800955057144165, -0.49509960412979126, -0.06175398826599121, -1.0082215070724487, -2.200223207473755, 0.5893546342849731};
 real A1[0:19]={0.8458104729652405, -0.9547175168991089, -0.880390465259552, -0.20010432600975037, -0.2598811984062195, 0.80960613489151, -0.7797866463661194, -0.26906993985176086, -0.8192005157470703, 0.6226937770843506, 0.4959842562675476, -0.6853398680686951, -0.7132633924484253, -0.6193597912788391, 0.4001277983188629, -0.05962100625038147, -0.2167469561100006, 0.7527454495429993, 0.0611364021897316, -0.41676127910614014};
 real B0[0:19]={0.30194926261901855, 0.15870119631290436, -0.048778239637613297, 0.0, 0.0, 0.09299585223197937, -0.07427426427602768, 0.0, -0.059493981301784515, 0.04977544769644737, -0.0717364102602005, -0.06986495852470398, -0.1104719489812851, -0.044989269226789474, 0.15013085305690765, 0.0, 0.0, 0.09558190405368805, 0.26002955436706543, -0.1739768385887146};
 real Ja[0:19];

 real B;
 real C0[0:19]= {-1.5632469654083252, -1.6555047035217285, 1.0907583236694336, 2.0045907497406006, 0.9249387383460999, -1.405918002128601, -1.0826996564865112, 0.07828149199485779, 1.2674630880355835, -0.31614255905151367, -0.31869035959243774, -0.08016299456357956, 1.9943336248397827, 1.5866727828979492, 1.1512898206710815, -0.9329212307929993, 0.06674136966466904, 1.9045380353927612, -1.520448923110962, 1.8805756568908691 };
 real C1[0:19]= {1.5539113283157349, 2.048854351043701, 2.3947784900665283, -0.9077812433242798, -3.9553234577178955, 1.5349334478378296, 1.1186096668243408, -0.31137987971305847, 0.2826046645641327, 1.2111997604370117, 0.23433537781238556, 0.07136905938386917, -1.3674607276916504, -0.8896675705909729, -0.8554133772850037, 1.0881175994873047, 0.3423652648925781, -1.4217932224273682, 1.6226205825805664, -1.2560575008392334 };
 real C2[0:19]= {2.1907148361206055, 2.072525978088379, -0.1319877803325653, -2.1880085468292236, -3.1681575775146484, 2.1808724403381348, 1.2628213167190552, 0.23722529411315918, -1.173609972000122, 0.6453416347503662, -0.004999422933906317, 0.13104791939258575, -2.2482573986053467, -2.1151630878448486, -2.225313425064087, 1.3550139665603638, -0.3643828332424164, -2.1855955123901367, 2.336289405822754, -2.501647472381592 };
 real C3[0:19]= {0.23231065273284912, 0.07256895303726196, -0.18406113982200623, 0.11638063192367554, 0.023437142372131348, 0.3298336863517761, 0.36902815103530884, -0.08601278066635132, -0.0701187252998352, 0.1865222454071045, 0.010351598262786865, -0.19002366065979004, -0.3133586347103119, -0.3843557834625244, 0.2969834804534912, 0.32779955863952637, 0.22624337673187256, -0.31339138746261597, 0.3445916771888733, 0.3793722987174988 };
 real C4[0:19]= {0.33341532945632935, -0.38132667541503906, 0.1449008584022522, -0.06665536761283875, -0.21970856189727783, -0.33309057354927063, -0.30378037691116333, -0.058847904205322266, 0.01823994517326355, 0.04530194401741028, -0.2205357402563095, 0.08526059985160828, 0.2915732264518738, 0.07964462041854858, -0.1004534363746643, 0.15644794702529907, -0.1539210081100464, -0.10037180781364441, -0.3775878846645355, 0.02422979474067688 };
 real C5[0:19]= {-0.9268413782119751, -0.34240061044692993, 0.09906449913978577, 0.5926259756088257, 0.5494812726974487, -0.7198352217674255, -0.47030624747276306, -0.3456439971923828, 1.9252644777297974, 0.05689924582839012, -0.5648325085639954, 0.21512973308563232, 1.1451783180236816, 0.6656522154808044, 0.553045392036438, -0.6889684200286865, -0.07130546867847443, 0.654330849647522, -0.3730442523956299, 0.6082335114479065 };
 real C6[0:19]= {0.6182355880737305, 0.903232991695404, -1.704067587852478, -0.4367164969444275, -6.339193344116211, 0.13247108459472656, 0.25914257764816284, 0.11805778741836548, -1.6207399368286133, -0.09015139937400818, 0.02909713052213192, -0.0071346089243888855, -0.5583640336990356, -0.6264196038246155, -0.6417662501335144, 0.4173116385936737, -0.20194318890571594, -0.27305886149406433, 0.6004984974861145, -0.40917712450027466 };
 real C7[0:19]= {0.23082423210144043, -0.32070687413215637, -0.0014264583587646484, -0.14579534530639648, 0.3318132162094116, 0.21739047765731812, 0.31877225637435913, 0.06888267397880554, 0.014798074960708618, 0.16015326976776123, 0.01562395691871643, 0.3644734025001526, -0.30226415395736694, -0.34524035453796387, 0.17957282066345215, 0.3210989236831665, -0.2857113778591156, -0.15928997099399567, 0.13540560007095337, -0.14270134270191193 };
 real C8[0:19]= {1.176100492477417, 1.3719260692596436, -2.257763147354126, -0.9393381476402283, -3.5672130584716797, 0.7821534276008606, 0.761526346206665, -0.16495561599731445, -4.891093730926514, 0.8131938576698303, 0.01838955655694008, -0.05705700069665909, -1.3686951398849487, -1.231506109237671, -0.9110466837882996, 0.6867903470993042, -0.1967955082654953, -1.4940518140792847, 1.1631958484649658, -0.8205981254577637 };
 real C9[0:19]= {-0.2645646929740906, 0.48947790265083313, 1.171091079711914, 0.09505543112754822, 2.6295511722564697, 0.33862897753715515, -0.1278400421142578, -0.3312651216983795, 0.510778546333313, -0.587327241897583, 0.3402479588985443, -0.2694120705127716, 0.6286929845809937, 0.3147171437740326, 0.0357799306511879, 0.39879029989242554, 0.007411864586174488, 0.004015252459794283, 0.0003287610597908497, -0.058428097516298294 };
 real C10[0:19]= {0.06217418238520622, -0.09791559725999832, -0.3499923646450043, -0.1438901424407959, 0.9286947846412659, 0.45490318536758423, 0.06854525208473206, -0.10965907573699951, -1.8927264213562012, -0.19527879357337952, -0.006667654030025005, 0.2648603320121765, 0.47384893894195557, 0.2785921096801758, 0.16530419886112213, -0.17003558576107025, -0.0037650195881724358, 0.11311828345060349, 0.11860471963882446, -0.00973447598516941 };
 real C11[0:19]= {0.44857126474380493, 0.7294043302536011, -1.5220869779586792, -0.6715737581253052, -10.806166648864746, 0.7383050322532654, 0.5251350998878479, -0.2896896004676819, -3.515683650970459, -0.046555910259485245, -0.4010295867919922, 0.24057628214359283, 0.007185178343206644, -0.6101322770118713, -0.4728853106498718, 0.08757252991199493, 0.36352670192718506, -0.6570355296134949, 0.8652383089065552, -0.698235273361206 };
 real C12[0:19]= {0.9429590702056885, 0.6707266569137573, -1.1549216508865356, -1.0273271799087524, -5.419482231140137, 1.0205814838409424, 0.7149221897125244, -0.14836736023426056, -2.986832857131958, 0.3372875154018402, -0.25119730830192566, -0.4377291202545166, -0.3448357880115509, -0.6499197483062744, -0.7438271641731262, 0.9612975120544434, -0.300808310508728, -1.0648455619812012, 1.1598329544067383, -0.45036885142326355 };
 real C13[0:19]= {0.25342753529548645, 0.3618687689304352, 0.11407826840877533, -0.05721306800842285, -4.684574127197266, 0.27029135823249817, 0.08400426805019379, 0.12991863489151, -0.7442678213119507, -0.12319365888834, -0.18556104600429535, -0.37018275260925293, 0.15680894255638123, -0.009920499287545681, -0.28660881519317627, -0.18200194835662842, -0.3875328600406647, 0.21735067665576935, 0.31331485509872437, -0.05739628151059151 };
 real C14[0:19]= {-0.232443168759346, 0.23798952996730804, 0.7061636447906494, 0.5392754077911377, -0.4921213388442993, 0.07868827879428864, 0.0810178592801094, 0.01276707649230957, 0.7899901866912842, 0.5036451816558838, -0.4299471974372864, -0.019834307953715324, 0.8444691300392151, 0.5945081114768982, 1.0917423963546753, 0.032661475241184235, -0.07232491672039032, 0.732600748538971, 0.04449257627129555, 0.1796887069940567 };
 real C15[0:19]= {-0.350304514169693, -0.2491646558046341, 0.3020455837249756, 0.1007075309753418, 0.3222154974937439, -0.2786085605621338, -0.1599535197019577, 0.290014386177063, 0.19741183519363403, -0.16667109727859497, -0.1775491088628769, 0.2642586827278137, 0.22804880142211914, -0.03222551941871643, 0.03635796904563904, 0.04056292772293091, 0.25396424531936646, -0.12742021679878235, 0.031089842319488525, -0.22392652928829193 };
 real C16[0:19]= {-0.00680464506149292, 0.3457416892051697, 0.062058061361312866, -0.25556355714797974, 0.2824709415435791, 0.22724276781082153, 0.21867835521697998, -0.2522317171096802, -0.3123282194137573, -0.2523188591003418, 0.30076199769973755, -0.18768416345119476, 0.25437211990356445, -0.35018283128738403, -0.06546640396118164, 0.3867388367652893, -0.2967013716697693, -0.1961475908756256, -0.013716250658035278, 0.03998035192489624 };
 real C17[0:19]= {-0.8847993612289429, -1.0765924453735352, 1.8453969955444336, 1.428045630455017, 0.710106372833252, -0.5939167737960815, -1.0851868391036987, -0.31018558144569397, 1.706517219543457, -0.12572751939296722, 0.2220303863286972, -0.4177400469779968, 1.441965103149414, 1.1027752161026, 1.4047784805297852, -0.7668825387954712, -0.17852607369422913, 1.5232675075531006, -1.105327844619751, 1.500550627708435 };
 real C18[0:19]= {-5.966418266296387, -6.162312030792236, 7.901619911193848, 6.305689811706543, 1.0642173290252686, -6.232049465179443, -6.698083877563477, 0.29115986824035645, 6.6493306159973145, -6.705342769622803, 0.029683711007237434, -0.252329021692276, 7.208858966827393, 6.745951175689697, 6.632342338562012, -7.120790481567383, -0.44227534532546997, 6.572571277618408, -6.248635292053223, 6.762152671813965 };
 real C19[0:19]= {0.03850898519158363, 0.5095313191413879, 0.24003538489341736, -0.20230215787887573, -0.7210386395454407, 0.4978201985359192, 0.19071969389915466, 0.09316933155059814, -0.4814574122428894, -0.03947834298014641, -0.3559994101524353, 0.31163784861564636, 0.4007740020751953, 0.07341009378433228, 0.15576456487178802, 0.24635940790176392, -0.26427215337753296, 0.17828194797039032, 0.23237740993499756, 0.31602928042411804 };
 real D0[0:19]={-0.012436825782060623, -0.04016644135117531, 0.8946557641029358, 0.2897469401359558, -0.530421793460846, 0.03894456848502159, -0.0819280594587326, 0.0, 0.22592388093471527, -0.03625650331377983, -0.040867701172828674, -0.07229921966791153, 0.3269389271736145, 0.1384098082780838, 0.19175167381763458, -0.1083434671163559, -0.04589833691716194, 0.2304258942604065, -0.05841274932026863, 0.20411543548107147};
 real Jb[0:19];

 real E0[0:19]={2.902656316757202, 2.2720463275909424, -1.2640730142593384, -3.0762581825256348, -0.8862296938896179, 1.4071403741836548, 2.7879130840301514, 0.02756589651107788, -7.951748847961426, 0.6520615220069885, 0.416920006275177, 0.1157117709517479, -1.1880382299423218, -5.9883856773376465, -5.250517845153809, 3.066466808319092, 0.46074527502059937, -3.878586530685425, 1.731016993522644, -2.3920693397521973};
 real E1[0:19]={-2.037400960922241, -1.7663074731826782, -1.1544657945632935, 1.5064892768859863, -5.476751804351807, -1.5596853494644165, -1.3452595472335815, -0.12309959530830383, 3.538821220397949, -1.2324897050857544, 0.2466689795255661, 0.10556819289922714, -0.1521490067243576, 3.8040921688079834, 2.872123956680298, -1.766772747039795, -0.00898171216249466, 2.022996664047241, -1.6158260107040405, 0.2861712574958801};

 real F0[0:1]={-0.3807264268398285, -0.2138645350933075};

 real C;
 real G0[0:19]={-0.3974478840827942, -0.26684507727622986, 1.1052863597869873, 1.576120376586914, 0.05880742520093918, -0.9688954949378967, -0.2637615203857422, 0.48765480518341064, -0.3038824200630188, 1.5539000034332275, -0.007757425308227539, -0.003136157989501953, -0.47998732328414917, 0.6505439281463623, -0.407346248626709, -0.29844510555267334, -0.06218606233596802, -1.0823019742965698, 0.695993185043335, -0.026704639196395874};
 real G1[0:19]={-5.224213600158691, -0.1933097541332245, -0.016602806746959686, -0.49058979749679565, -0.3429899215698242, 0.3576222360134125, 0.03911576792597771, 0.0478491447865963, -0.06975755095481873, -0.48935410380363464, -0.2051619589328766, -0.44075989723205566, -0.0068852901458740234, 0.36336639523506165, 0.6201580762863159, -0.32922035455703735, -0.5040256977081299, -0.08609870076179504, -1.0430036783218384, -0.04289960861206055};
 real G2[0:19]={0.35174673795700073, -0.4779698848724365, 0.011991206556558609, -0.52849280834198, -0.23662321269512177, 0.3929803669452667, -0.14474628865718842, -0.12722650170326233, -0.29921168088912964, -0.9350464940071106, -0.4825385808944702, -0.13603761792182922, -0.5043887495994568, -0.3597402274608612, 0.3587731719017029, -0.4284873604774475, -0.2959604561328888, 0.3853202760219574, -0.3344389498233795, -0.2295498251914978};
 real H0[0:19]={-0.02496795542538166, 0.0, -0.4801148474216461, -0.35291802883148193, -0.05419008433818817, 0.4559321701526642, -0.031755682080984116, -0.3518828749656677, 0.0, -0.35548916459083557, 0.0, 0.0, 0.0, -0.182490274310112, 0.18385164439678192, 0.0, 0.0, 0.2111804187297821, -0.47818872332572937, 0.0};
 real Jc[0:19];

 real D;
 real I0[0:19]={-0.0493297353386879, -0.27714091539382935, -0.9560543298721313, -1.5955199003219604, -1.7282005548477173, -0.6085686087608337, 0.5321987867355347, 0.011057227849960327, -4.505071640014648, 0.3684387803077698, -0.5079936981201172, -0.799476683139801, -1.1069880723953247, -0.5633540749549866, 0.362076073884964, -0.2352127730846405, 0.2323724776506424, 1.6648573875427246, -0.7093531489372253, 0.03160843625664711};
 real I1[0:19]={0.3342285752296448, -0.22175812721252441, 0.09133511781692505, -0.16348032653331757, 0.27088993787765503, -0.23571361601352692, 0.25996196269989014, 0.11482065916061401, -0.34737876057624817, 0.21093708276748657, -0.3104217052459717, -0.30517470836639404, -0.09859278798103333, -0.16140702366828918, -0.34807148575782776, -0.10725337266921997, -0.278141587972641, 0.13245612382888794, 0.22691214084625244, -0.16224528849124908};
 real I2[0:19]={0.3415859639644623, -0.23470820486545563, 0.14414186775684357, -0.5337178707122803, -0.25206369161605835, 0.31788063049316406, -0.9470663666725159, 0.38961026072502136, -0.011407734826207161, -1.9914578199386597, -0.20487046241760254, 0.02342824824154377, -2.3122496604919434, 0.0954924151301384, 0.38575929403305054, 0.740200936794281, -0.35381588339805603, 0.288790225982666, -0.026233654469251633, 0.24546828866004944};
 real I3[0:19]={-31.004762649536133, -0.10203704237937927, 0.16450439393520355, 0.27529382705688477, -0.37323668599128723, 0.5007857084274292, -6.6091837882995605, -2.242349624633789, 0.17891182005405426, -0.9591235518455505, 0.6656919717788696, 0.13367727398872375, -20.30624771118164, 0.37739068269729614, 0.003829982364550233, -17.221027374267578, 0.03567969426512718, -9.832404136657715, 0.510516881942749, 0.22011539340019226};
 real I4[0:19]={-0.11556839942932129, 0.050682902336120605, -0.045824866741895676, -0.13880084455013275, -0.09350129961967468, 0.3887154757976532, 0.15863968431949615, -0.2552219033241272, 0.3485114574432373, -0.36846715211868286, 0.19218435883522034, -0.19856210052967072, -0.15448175370693207, 0.13397204875946045, 0.3385286331176758, -0.047036170959472656, 0.19693785905838013, -0.07591134309768677, -0.20769086480140686, 0.37682080268859863};
 real I5[0:19]={-0.012419793754816055, -0.3817215859889984, -0.5121349692344666, 0.20310424268245697, -0.059067897498607635, -0.3243879973888397, 0.3858620524406433, -0.6998966336250305, 0.05602944269776344, 0.34472018480300903, -0.5087983012199402, -0.6652002930641174, 0.6816887259483337, -0.2095966786146164, -0.41707009077072144, -1.6001988649368286, -0.033085621893405914, 0.34301406145095825, -0.3856520354747772, -0.25923219323158264};
 real I6[0:19]={-0.3303561210632324, -0.306558221578598, 0.18305209279060364, 0.30720698833465576, 0.3722357749938965, 0.26492634415626526, 0.022358538582921028, 0.2825920581817627, 0.2272382378578186, -0.27678993344306946, 0.3539636433124542, -0.15282192826271057, 0.2566567361354828, 0.20235587656497955, 0.15054583549499512, 0.22987300157546997, -0.09274613857269287, 0.3447204828262329, 0.04333728179335594, 0.0878916084766388};
 real I7[0:19]={0.29237690567970276, 0.09563566744327545, -1.0655264854431152, -0.13169889152050018, 3.7037997245788574, -0.6889787316322327, 1.816612720489502, 0.802635669708252, -1.599086046218872, -0.03282424807548523, -0.5946250557899475, -0.8562833070755005, 0.9435555934906006, -0.7497179508209229, 0.17110596597194672, -0.43392762541770935, -0.19015732407569885, 0.3312835693359375, -0.9284235239028931, 0.21194963157176971};
 real I8[0:19]={0.32960081100463867, -0.20108939707279205, 0.04805299639701843, -0.2730633020401001, 0.13668292760849, -0.1417427659034729, -0.2441447228193283, -0.04241034388542175, -0.17143090069293976, 0.35864996910095215, -0.2088385820388794, 0.17472964525222778, 0.09137001633644104, -0.17078064382076263, -0.20175404846668243, 0.09146422147750854, -0.26179784536361694, 0.23854023218154907, 0.0718860924243927, -0.3407546281814575};
 real I9[0:19]={6.21685791015625, -0.1986796110868454, -0.17095042765140533, -1.1234791278839111, -1.157270073890686, -0.2863337993621826, -4.873709678649902, 0.6563183069229126, 0.04140452295541763, 0.8430874347686768, -0.14273087680339813, -0.10133349895477295, -16.510221481323242, -0.031096002086997032, -0.4153384268283844, 0.9397072196006775, -0.09678204357624054, -3.7025911808013916, -0.38810423016548157, -0.19317933917045593};
 real I10[0:19]={0.09476080536842346, -0.1714109629392624, -0.24526286125183105, 0.16277557611465454, 0.3430681824684143, 0.1975039839744568, -0.3803882300853729, 0.16124439239501953, -0.2513386011123657, 0.1552472710609436, -0.36701440811157227, -0.35651442408561707, -0.27031299471855164, -0.25678551197052, 0.2724839448928833, 0.26387453079223633, -0.0957968533039093, 0.11257848143577576, -0.26786932349205017, -0.08189049363136292};
 real I11[0:19]={0.18547707796096802, -0.22416475415229797, -0.183719202876091, 0.33997678756713867, -0.20848114788532257, -0.14326192438602448, -0.021585285663604736, 0.21328622102737427, -0.25678354501724243, -0.3235093653202057, 0.16237753629684448, 0.02395525574684143, -0.2912251353263855, -0.14160656929016113, 0.1556771993637085, 0.3841896653175354, -0.17836381494998932, -0.29837217926979065, -0.2775866389274597, 0.3404339551925659};
 real I12[0:19]={-0.11333426833152771, -0.13154113292694092, -0.297110915184021, 0.09427860379219055, -0.14598500728607178, -0.04357731342315674, 0.07879409193992615, 0.16633951663970947, -0.2498338371515274, 0.23049038648605347, -0.31230098009109497, -0.24232961237430573, -0.08226409554481506, -0.3042539954185486, -0.04122146964073181, -0.11185914278030396, -0.25310105085372925, -0.015164405107498169, -0.010269582271575928, -0.08986157178878784};
 real I13[0:19]={-0.33538204431533813, 0.2772015333175659, 0.03170967474579811, -1.1870402097702026, -0.10823644697666168, -0.3307487666606903, 0.4806004762649536, 0.28545960783958435, -0.43836843967437744, -0.6027956604957581, -0.037026796489953995, 0.05497078225016594, 0.08854811638593674, 0.3231457769870758, -1.420390009880066, 0.42737701535224915, 0.14634184539318085, -0.5970602631568909, 0.3080994784832001, -0.32405176758766174};
 real I14[0:19]={0.24543504416942596, -0.4247715473175049, 0.17545713484287262, -0.014800353907048702, 0.0710633248090744, 0.30141809582710266, 0.36087653040885925, -0.12785778939723969, -0.05879216268658638, 0.06441309303045273, 0.3196030259132385, 0.3076814115047455, 0.9963635802268982, 0.1801908165216446, -0.009685690514743328, -0.6036316752433777, -0.366058349609375, 0.20343372225761414, 0.04257119819521904, -0.4501277506351471};
 real I15[0:19]={-0.3289721608161926, -0.3025694489479065, -0.2581920921802521, -0.38464635610580444, -0.1612880975008011, 0.05703511834144592, 0.3370656967163086, 0.12692683935165405, 0.21253573894500732, -0.26535704731941223, 0.27587181329727173, -0.05696907639503479, -0.21813926100730896, 0.11066022515296936, 0.29103177785873413, -0.10236835479736328, -0.056172460317611694, -0.014223188161849976, -0.375985324382782, 0.0887933075428009};
 real I16[0:19]={0.07540690898895264, -0.3551322817802429, -0.0034611523151397705, 0.3794211745262146, -0.07639878988265991, 0.31625163555145264, 0.0785863995552063, -0.07193559408187866, 0.16461259126663208, -0.022161394357681274, -0.11001726984977722, 0.15430474281311035, -0.019734352827072144, 0.15134215354919434, 0.2936229109764099, -0.11674860119819641, 0.18444931507110596, -0.11146706342697144, 0.167619526386261, 0.31571483612060547};
 real I17[0:19]={0.8704786896705627, 0.2784842848777771, 0.9983776807785034, 0.41662704944610596, 0.6446795463562012, 1.0790209770202637, -0.5473703742027283, -0.2512604594230652, -1.8812578916549683, -0.03379497677087784, 1.2335689067840576, 1.1596662998199463, 1.2381401062011719, 0.669241189956665, -1.208356261253357, 0.23218035697937012, 0.07340861856937408, -19.551406860351562, 1.2249207496643066, 0.29595738649368286};
 real I18[0:19]={1.0108482837677002, 0.25335657596588135, 0.31009963154792786, -0.457962304353714, 0.798334538936615, -0.2307787984609604, 1.5985182523727417, 0.24229353666305542, 0.8286380767822266, 0.9547308087348938, -0.16742438077926636, 0.490810364484787, -0.42324620485305786, -0.18858611583709717, -0.9654871821403503, 0.3099993169307709, 0.26258885860443115, -1.6669801473617554, 0.47658610343933105, -0.3056851625442505};
 real I19[0:19]={-0.08208143711090088, -0.2791196405887604, -0.2537466287612915, 0.2426663637161255, -0.05584338307380676, -0.11648663878440857, -0.2703973054885864, 0.2573028802871704, 0.2968898415565491, -0.002268850803375244, 0.2637820243835449, -0.3007831573486328, 0.3023742437362671, -0.36222586035728455, -0.3102506697177887, -0.06256023049354553, -0.18642714619636536, 0.26294976472854614, -0.025707483291625977, 0.23908406496047974};
 real J0[0:19]={-0.04210628941655159, -0.08804205805063248, 0.20839180052280426, 0.21917970478534698, 0.3581155836582184, 0.2067672610282898, 0.07009269297122955, -0.0030403640121221542, 0.11572984606027603, -0.407391756772995, 0.28955793380737305, 0.27445971965789795, 0.42010459303855896, 0.2617869973182678, -0.15170495212078094, -0.1997404247522354, -0.09629018604755402, -0.1689697951078415, 0.3145269751548767, -0.13099420070648193};
 real Jd[0:19];

 real K0[0:19]={-3.180414915084839, 0.09634554386138916, 0.06483206897974014, -1.4895769357681274, -0.5772333145141602, 0.09667406231164932, -2.938159465789795, -0.9512606859207153, -0.257285475730896, 0.05503387004137039, 0.2895592749118805, 0.1951071172952652, 1.7171393632888794, 0.23964491486549377, -1.787534236907959, -10.256224632263184, 0.07919956743717194, -1.434533953666687, 0.36127573251724243, 0.19233514368534088};

 real L0=0.3741384446620941;

 real Vgs,Idaa,Idab,Idb;
 real h;

 analog begin

 // bound time step
 $bound_step(time_step);

 @(initial_step("tran")) begin
   W=1;
 end

 Vgs = V(g,s);

 // normalization
 Vgs = (Vgs+1.5)/2.7;

 // MLP model one
 for(h=0; h<=19; h=h+1) begin
  A = A0[h]*Vgs+A1[h]*W+B0[h];
  if (A <= 0)
   Ja[h] = 0;
  else if (A > 0)
   Ja[h] = A;
 end

 for(h=0; h<=19; h=h+1) begin
  B = C0[h]*Ja[0]+C1[h]*Ja[1]+C2[h]*Ja[2]+C3[h]*Ja[3]+C4[h]*Ja[4]+C5[h]*Ja[5]+C6[h]*Ja[6]+C7[h]*Ja[7]+C8[h]*Ja[8]+C9[h]*Ja[9]+C10[h]*Ja[10]+C11[h]*Ja[11]+C12[h]*Ja[12]+C13[h]*Ja[13]+C14[h]*Ja[14]+C15[h]*Ja[15]+C16[h]*Ja[16]+C17[h]*Ja[17]+C18[h]*Ja[18]+C19[h]*Ja[19]+D0[h];
  if (B <= 0)
   Jb[h] = 0;
  else if (B > 0)
   Jb[h] = B;
 end

 Idaa = 0;
 for(h=0; h<=19; h=h+1) begin
  Idaa = Idaa+Jb[h]*E0[h];
 end

 Wa =Idaa+F0[0];
 Wa = (-1)*Wa;
 Wa = 1 / (1+exp(Wa));

 Idab = 0;
 for(h=0; h<=19; h=h+1) begin
  Idab = Idab+Jb[h]*E1[h];
 end

 Wb =Idab+F0[1];
 Wb = (-1)*Wb;
 Wb = 1 / (1+exp(Wb));

 // MLP model two
 for(h=0; h<=19; h=h+1) begin
  C = G0[h]*Vgs+G1[h]*Wa+G2[h]*Wb+H0[h];
  if (C <= 0)
   Jc[h] = 0;
  else if (C > 0)
   Jc[h] = C;
 end

 for(h=0; h<=19; h=h+1) begin
  D = I0[h]*Jc[0]+I1[h]*Jc[1]+I2[h]*Jc[2]+I3[h]*Jc[3]+I4[h]*Jc[4]+I5[h]*Jc[5]+I6[h]*Jc[6]+I7[h]*Jc[7]+I8[h]*Jc[8]+I9[h]*Jc[9]+I10[h]*Jc[10]+I11[h]*Jc[11]+I12[h]*Jc[12]+I13[h]*Jc[13]+I14[h]*Jc[14]+I15[h]*Jc[15]+I16[h]*Jc[16]+I17[h]*Jc[17]+I18[h]*Jc[18]+I19[h]*Jc[19]+J0[h];
  if (D <= 0)
   Jd[h] = 0;
  else if (D > 0)
   Jd[h] = D;
 end

 Idb = 0;
 for(h=0; h<=19; h=h+1) begin
  Idb = Idb+Jd[h]*K0[h];
 end

 Idb = (Idb+L0)*(4.046240308266771)-7.046240308266771;

 Vgs = (Vgs*2.7)-1.5;

 if (Vgs >= 0)
  Idb = pow(10, Idb);
 else if (Vgs < 0)
  Idb = (-1)*pow(10, Idb);

 if (Wa <= Wb)
  W = 1;
 else if (Wa > Wb)
  W = 0;

 I(g,s) <+ Idb;
 end
endmodule
